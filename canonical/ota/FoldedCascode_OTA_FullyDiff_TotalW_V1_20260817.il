;=============================================================================
; Fully Differential Folded-Cascode OTA - TotalW V1 - 2026-08-17
; Cadence Virtuoso IC6.1.7 / SKILL - PDK target: tsmcN65 - 2026-08-17
;
; TotalW-first generator: W/finger = TotalW/NF, totalM = NF*M.
; Routing contract: one isolated labeled stub per terminal; no
; device-to-device wires. Schematic candidate; electrical performance
; is NOT verified. All source text is ASCII-only.
;
;   M1  NMOS input pair (G=VINP D=NLEFT S=TAIL B=VSS)
;   M2  NMOS input pair (G=VINN D=NRIGHT S=TAIL B=VSS)
;   M3  PMOS top device L (G=VBP2 D=NLEFT S=VDD B=VDD)
;   M4  PMOS top device R (G=VBP2 D=NRIGHT S=VDD B=VDD)
;   M5  PMOS folded cascode L (G=VBP1 D=VOUTP S=NLEFT B=VDD)
;   M6  PMOS folded cascode R (G=VBP1 D=VOUTN S=NRIGHT B=VDD)
;   M7  NMOS folded cascode L (G=VBN1 D=VOUTP S=LEFT_SINK B=VSS)
;   M8  NMOS folded cascode R (G=VBN1 D=VOUTN S=RIGHT_SINK B=VSS)
;   M9  NMOS lower sink L (G=VBN2 D=LEFT_SINK S=VSS B=VSS)
;   M10 NMOS lower sink R (G=VBN2 D=RIGHT_SINK S=VSS B=VSS)
;   M11 NMOS tail source (G=VBN_TAIL D=TAIL S=VSS B=VSS)
;=============================================================================

(setq FDF_LIB "tsmcN65")
(setq FDF_NMOS "nch")
(setq FDF_PMOS "pch")
(setq FDF_STUB 0.75)
(setq FDF_WIRE 0.0625)
procedure(FDF_ToFloat(val)
    cond(
        (numberp(val) float(val))
        (stringp(val)
            let((parsed)
                parsed=nil
                errset(parsed=cdfParseFloatString(val) t)
                parsed
            )
        )
        (t nil)
    )
)

procedure(FDF_ValueMatches(got expect)
    let((gn en)
        gn=FDF_ToFloat(got)
        en=FDF_ToFloat(expect)
        if(gn && en
            then abs(gn-en) < 1e-12 * max(1.0 abs(en))
            else equal(got expect)
        )
    )
)

procedure(FDF_OpenMaster(lib cell)
    let((master)
        master=dbOpenCellViewByType(lib cell "symbol" "" "r")
        unless(master
            error("FDF: cannot open %s/%s/symbol.\n" lib cell)
        )
        master
    )
)

procedure(FDF_SetMOS(inst TotalW L NF M)
    let((cdf nfInt mInt WperFinger totalM)
        cdf=cdfGetInstCDF(inst)
        unless(cdf error("FDF: CDF missing on %s.\n" inst~>name))
        unless(cdf->w && cdf->l && cdf->wf && cdf->fingers && cdf->simM && cdf->totalM && cdf->nf && cdf->m
            error("FDF: incomplete MOS CDF on %s.\n" inst~>name))
        nfInt=atoi(NF)
        mInt=atoi(M)
        unless(nfInt>0 error("FDF: NF must be >= 1 on %s.\n" inst~>name))
        unless(mInt>0 error("FDF: M must be >= 1 on %s.\n" inst~>name))
        WperFinger=FDF_ToFloat(TotalW)/float(nfInt)
        totalM=sprintf(nil "%d" (nfInt*mInt))
        cdf->w->value=sprintf(nil "%g" WperFinger)
        cdf->l->value=L
        cdf->wf->value=TotalW
        cdf->fingers->value=NF
        cdf->simM->value=M
        cdf->totalM->value=totalM
        cdf->nf->value=NF
        cdf->m->value=M
        unless(FDF_ValueMatches(cdf->w->value WperFinger)
            error("FDF: W/finger read-back mismatch on %s.\n" inst~>name))
        unless(FDF_ValueMatches(cdf->l->value L)
            error("FDF: L read-back mismatch on %s.\n" inst~>name))
        unless(FDF_ValueMatches(cdf->wf->value TotalW)
            error("FDF: TotalW read-back mismatch on %s.\n" inst~>name))
        unless(FDF_ValueMatches(cdf->fingers->value NF)
            error("FDF: fingers read-back mismatch on %s.\n" inst~>name))
        unless(FDF_ValueMatches(cdf->simM->value M)
            error("FDF: simM read-back mismatch on %s.\n" inst~>name))
        unless(FDF_ValueMatches(cdf->totalM->value totalM)
            error("FDF: totalM read-back mismatch on %s.\n" inst~>name))
        unless(FDF_ValueMatches(cdf->nf->value NF)
            error("FDF: nf read-back mismatch on %s.\n" inst~>name))
        unless(FDF_ValueMatches(cdf->m->value M)
            error("FDF: m read-back mismatch on %s.\n" inst~>name))
        printf("FDF: %s TotalW=%s W/finger=%s L=%s NF=%s M=%s totalM=%s\n"
            inst~>name TotalW cdf->w->value L NF M totalM)
        t
    )
)

procedure(FDF_PinCenter(inst pinName)
    let((term pin fig)
        term=dbFindTermByName(inst~>master pinName)
        unless(term error("FDF: terminal %s missing on %s.\n" pinName inst~>name))
        pin=car(term~>pins)
        unless(pin error("FDF: pin figure missing on %s.%s.\n" inst~>name pinName))
        fig=pin~>fig
        unless(fig error("FDF: figure missing on %s.%s.\n" inst~>name pinName))
        dbTransformPoint(centerBox(fig~>bBox) inst~>transform)
    )
)

procedure(FDF_PlaceMOS(cv master name xy TotalW L NF M orient)
    let((inst)
        inst=dbCreateInst(cv master name xy orient)
        unless(inst error("FDF: cannot create %s.\n" name))
        FDF_SetMOS(inst TotalW L NF M)
        inst
    )
)

procedure(FDF_StubEnd(inst pinName)
    let((g b s d p ref dx dy)
        g=FDF_PinCenter(inst "G")
        b=FDF_PinCenter(inst "B")
        s=FDF_PinCenter(inst "S")
        d=FDF_PinCenter(inst "D")
        p=FDF_PinCenter(inst pinName)
        cond(
            (equal(pinName "G") ref=b)
            (equal(pinName "B") ref=g)
            (equal(pinName "S") ref=d)
            (equal(pinName "D") ref=s)
            (t error("FDF: unsupported terminal %s.\n" pinName))
        )
        dx=car(p)-car(ref)
        dy=cadr(p)-cadr(ref)
        if(abs(dx)>=abs(dy)
            then if(dx<0.0
                then list(car(p)-FDF_STUB cadr(p))
                else list(car(p)+FDF_STUB cadr(p)))
            else if(dy<0.0
                then list(car(p) cadr(p)-FDF_STUB)
                else list(car(p) cadr(p)+FDF_STUB))
        )
    )
)

procedure(FDF_LabelMOSTerminal(cv inst pinName netName)
    let((p e wire label)
        p=FDF_PinCenter(inst pinName)
        e=FDF_StubEnd(inst pinName)
        wire=schCreateWire(cv "route" "full" list(p e) FDF_WIRE FDF_WIRE 0)
        unless(wire error("FDF: stub creation failed on %s.%s.\n" inst~>name pinName))
        label=schCreateWireLabel(cv car(wire) e netName "lowerLeft" "R0" "stick" FDF_WIRE nil)
        unless(label error("FDF: label creation failed on %s.%s.\n" inst~>name pinName))
        printf("FDF: STUB %s.%s -> %s\n" inst~>name pinName netName)
        e
    )
)

procedure(FDF_SetVDC(inst value)
    let((cdf)
        cdf=cdfGetInstCDF(inst)
        unless(cdf error("FDF: VDC CDF missing on %s.\n" inst~>name))
        unless(cdf->vdc error("FDF: VDC parameter missing on %s.\n" inst~>name))
        cdf->vdc->value=value
        t
    )
)

procedure(FDF_VDCPinCenter(inst pinName)
    let((term pin fig)
        term=dbFindTermByName(inst~>master pinName)
        unless(term error("FDF: VDC terminal %s missing on %s.\n" pinName inst~>name))
        pin=car(term~>pins)
        unless(pin error("FDF: VDC pin figure missing on %s.%s.\n" inst~>name pinName))
        fig=pin~>fig
        unless(fig error("FDF: VDC figure missing on %s.%s.\n" inst~>name pinName))
        dbTransformPoint(centerBox(fig~>bBox) inst~>transform)
    )
)

procedure(FDF_CreateVDC(cv master name xy value plusNet minusNet)
    let((inst plus minus ep em wp wm gndMaster gndInst)
        inst=dbCreateInst(cv master name xy "R0")
        unless(inst error("FDF: cannot create VDC %s.\n" name))
        FDF_SetVDC(inst value)
        plus=FDF_VDCPinCenter(inst "PLUS")
        minus=FDF_VDCPinCenter(inst "MINUS")
        ep=list(car(plus) cadr(plus)+FDF_STUB)
        wp=schCreateWire(cv "route" "full" list(plus ep) FDF_WIRE FDF_WIRE 0)
        unless(wp error("FDF: VDC PLUS wiring failed for %s.\n" name))
        schCreateWireLabel(cv car(wp) ep plusNet "lowerLeft" "R0" "stick" FDF_WIRE nil)
        if(equal(plusNet "VSS") then
            gndMaster=FDF_OpenMaster("analogLib" "gnd")
            gndInst=dbCreateInst(cv gndMaster strcat(name "_GND") minus "R0")
            unless(gndInst error("FDF: cannot create GND instance for %s.\n" name))
        else
            em=list(car(minus) cadr(minus)-FDF_STUB)
            wm=schCreateWire(cv "route" "full" list(minus em) FDF_WIRE FDF_WIRE 0)
            unless(wm error("FDF: VDC MINUS wiring failed for %s.\n" name))
            schCreateWireLabel(cv car(wm) em minusNet "lowerLeft" "R0" "stick" FDF_WIRE nil)
        )
        printf("FDF: VDC %s = %sV PLUS=%s MINUS=%s\n" name value plusNet minusNet)
        inst
    )
)

procedure(FDF_CreatePin(cv pinMaster name direction xy)
    let((pin)
        pin=schCreatePin(cv pinMaster name direction nil xy "R0")
        unless(pin error("FDF: failed creating external pin %s.\n" name))
        printf("FDF: PIN %s direction=%s at %L\n" name direction xy)
        pin
    )
)
procedure(FDF_PlacePMOSAuto(cv master name xy TotalW L NF M)
    let((inst s d)
        inst=FDF_PlaceMOS(cv master name xy TotalW L NF M "R0")
        s=FDF_PinCenter(inst "S")
        d=FDF_PinCenter(inst "D")
        printf("FDF: PMOS %s candidate orient=%L S=%L D=%L\n" name inst~>orient s d)
        if(cadr(s)>cadr(d)
            then inst
            else
                dbDeleteObject(inst)
                inst=FDF_PlaceMOS(cv master name xy TotalW L NF M "MX")
                s=FDF_PinCenter(inst "S")
                d=FDF_PinCenter(inst "D")
                printf("FDF: PMOS %s fallback orient=%L S=%L D=%L\n" name inst~>orient s d)
                unless(cadr(s)>cadr(d)
                    error("FDF: PMOS %s cannot place source above drain in R0 or MX.\n" name))
                inst
        )
    )
)

procedure(CreateFoldedCascode_OTA_FullyDiff_TotalW_V1_20260817()
    let((cv nmos pmos vdcMaster pinMaster M1 M2 M3 M4 M5 M6 M7 M8 M9 M10 M11  V_VDD_SRC V_VBP2_SRC V_VBP1_SRC V_VBN1_SRC V_VBN2_SRC V_VBN_TAIL_SRC V_VINP_SRC V_VINN_SRC V_VSS_SRC)

        printf("\n============================================================\n")
        printf(" Fully Differential Folded-Cascode OTA - TotalW V1 - 2026-08-17\n")
        printf("============================================================\n")
        printf("VDD=2.00V  FULLY DIFFERENTIAL OUTPUTS: VOUTP / VOUTN\n")
        printf("BIASES: VBP2=1.55 VBP1=1.30 VBN1=0.65 VBN2=0.45 VBN_TAIL=0.65 (all vs VSS)\n")
        printf("CMFB REQUIRED but not implemented - outputs require external common-mode control\n")
        printf("TEMP=27C  CORNER=TT\n")
        printf("DEVICE=FDF/FDF\n" FDF_LIB FDF_NMOS)
        printf("DEVICE=FDF/FDF\n" FDF_LIB FDF_PMOS)
        printf("STATUS=SCHEMATIC CANDIDATE; PERFORMANCE NOT VERIFIED\n")
        printf("============================================================\n")

        cv=geGetEditCellView()
        unless(cv error("FDF: open a NEW EMPTY editable schematic first.\n"))
        unless(null(cv~>instances)
            error("FDF: target schematic is not empty. Use a new empty schematic.\n"))

        nmos=FDF_OpenMaster(FDF_LIB FDF_NMOS)
        pmos=FDF_OpenMaster(FDF_LIB FDF_PMOS)
        vdcMaster=FDF_OpenMaster("analogLib" "vdc")
        pinMaster=FDF_OpenMaster("basic" "iopin")

        M1=FDF_PlaceMOS(cv nmos "M1" -4:-4 "8u" "480n" "1" "1" "R0")
        M2=FDF_PlaceMOS(cv nmos "M2" 4:-4 "8u" "480n" "1" "1" "R0")
        M3=FDF_PlacePMOSAuto(cv pmos "M3" -4:12 "8u" "480n" "1" "1")
        M4=FDF_PlacePMOSAuto(cv pmos "M4" 4:12 "8u" "480n" "1" "1")
        M5=FDF_PlacePMOSAuto(cv pmos "M5" -4:8 "8u" "480n" "1" "1")
        M6=FDF_PlacePMOSAuto(cv pmos "M6" 4:8 "8u" "480n" "1" "1")
        M7=FDF_PlaceMOS(cv nmos "M7" -4:4 "4u" "480n" "1" "1" "R0")
        M8=FDF_PlaceMOS(cv nmos "M8" 4:4 "4u" "480n" "1" "1" "R0")
        M9=FDF_PlaceMOS(cv nmos "M9" -4:0 "6u" "1u" "1" "1" "R0")
        M10=FDF_PlaceMOS(cv nmos "M10" 4:0 "6u" "1u" "1" "1" "R0")
        M11=FDF_PlaceMOS(cv nmos "M11" 0:-8 "8u" "1u" "1" "1" "R0")

        FDF_LabelMOSTerminal(cv M1 "G" "VINP")
        FDF_LabelMOSTerminal(cv M1 "D" "NLEFT")
        FDF_LabelMOSTerminal(cv M1 "S" "TAIL")
        FDF_LabelMOSTerminal(cv M1 "B" "VSS")
        FDF_LabelMOSTerminal(cv M2 "G" "VINN")
        FDF_LabelMOSTerminal(cv M2 "D" "NRIGHT")
        FDF_LabelMOSTerminal(cv M2 "S" "TAIL")
        FDF_LabelMOSTerminal(cv M2 "B" "VSS")
        FDF_LabelMOSTerminal(cv M3 "G" "VBP2")
        FDF_LabelMOSTerminal(cv M3 "D" "NLEFT")
        FDF_LabelMOSTerminal(cv M3 "S" "VDD")
        FDF_LabelMOSTerminal(cv M3 "B" "VDD")
        FDF_LabelMOSTerminal(cv M4 "G" "VBP2")
        FDF_LabelMOSTerminal(cv M4 "D" "NRIGHT")
        FDF_LabelMOSTerminal(cv M4 "S" "VDD")
        FDF_LabelMOSTerminal(cv M4 "B" "VDD")
        FDF_LabelMOSTerminal(cv M5 "G" "VBP1")
        FDF_LabelMOSTerminal(cv M5 "D" "VOUTP")
        FDF_LabelMOSTerminal(cv M5 "S" "NLEFT")
        FDF_LabelMOSTerminal(cv M5 "B" "VDD")
        FDF_LabelMOSTerminal(cv M6 "G" "VBP1")
        FDF_LabelMOSTerminal(cv M6 "D" "VOUTN")
        FDF_LabelMOSTerminal(cv M6 "S" "NRIGHT")
        FDF_LabelMOSTerminal(cv M6 "B" "VDD")
        FDF_LabelMOSTerminal(cv M7 "G" "VBN1")
        FDF_LabelMOSTerminal(cv M7 "D" "VOUTP")
        FDF_LabelMOSTerminal(cv M7 "S" "LEFT_SINK")
        FDF_LabelMOSTerminal(cv M7 "B" "VSS")
        FDF_LabelMOSTerminal(cv M8 "G" "VBN1")
        FDF_LabelMOSTerminal(cv M8 "D" "VOUTN")
        FDF_LabelMOSTerminal(cv M8 "S" "RIGHT_SINK")
        FDF_LabelMOSTerminal(cv M8 "B" "VSS")
        FDF_LabelMOSTerminal(cv M9 "G" "VBN2")
        FDF_LabelMOSTerminal(cv M9 "D" "LEFT_SINK")
        FDF_LabelMOSTerminal(cv M9 "S" "VSS")
        FDF_LabelMOSTerminal(cv M9 "B" "VSS")
        FDF_LabelMOSTerminal(cv M10 "G" "VBN2")
        FDF_LabelMOSTerminal(cv M10 "D" "RIGHT_SINK")
        FDF_LabelMOSTerminal(cv M10 "S" "VSS")
        FDF_LabelMOSTerminal(cv M10 "B" "VSS")
        FDF_LabelMOSTerminal(cv M11 "G" "VBN_TAIL")
        FDF_LabelMOSTerminal(cv M11 "D" "TAIL")
        FDF_LabelMOSTerminal(cv M11 "S" "VSS")
        FDF_LabelMOSTerminal(cv M11 "B" "VSS")

        V_VDD_SRC=FDF_CreateVDC(cv vdcMaster "V_VDD_SRC" 0:16 "2.00" "VDD" "VSS")
        V_VBP2_SRC=FDF_CreateVDC(cv vdcMaster "V_VBP2_SRC" -16:12 "1.55" "VBP2" "VSS")
        V_VBP1_SRC=FDF_CreateVDC(cv vdcMaster "V_VBP1_SRC" -16:8 "1.30" "VBP1" "VSS")
        V_VBN1_SRC=FDF_CreateVDC(cv vdcMaster "V_VBN1_SRC" 16:4 "0.65" "VBN1" "VSS")
        V_VBN2_SRC=FDF_CreateVDC(cv vdcMaster "V_VBN2_SRC" 16:0 "0.45" "VBN2" "VSS")
        V_VBN_TAIL_SRC=FDF_CreateVDC(cv vdcMaster "V_VBN_TAIL_SRC" -16:-4 "0.65" "VBN_TAIL" "VSS")
        V_VINP_SRC=FDF_CreateVDC(cv vdcMaster "V_VINP_SRC" -16:-8 "1.00" "VINP" "VSS")
        V_VINN_SRC=FDF_CreateVDC(cv vdcMaster "V_VINN_SRC" 16:-8 "1.00" "VINN" "VSS")
        V_VSS_SRC=FDF_CreateVDC(cv vdcMaster "V_VSS_SRC" 0:-12 "0.0" "VSS" "VSS")

        FDF_CreatePin(cv pinMaster "VINP" "input" -14:-10)
        FDF_CreatePin(cv pinMaster "VINN" "input" 14:-10)
        FDF_CreatePin(cv pinMaster "VOUTP" "output" -10:6)
        FDF_CreatePin(cv pinMaster "VOUTN" "output" 10:6)
        FDF_CreatePin(cv pinMaster "VDD" "input" 0:18)
        FDF_CreatePin(cv pinMaster "VSS" "input" 0:-14)

        schCheck(cv)
        dbSave(cv)

        printf("\n============================================================\n")
        printf(" FDF GENERATOR COMPLETED\n")
        printf(" CDF       : w/l/wf/fingers/simM/totalM/nf/m explicit\n")
        printf(" ROUTING   : local isolated stub + net label\n")
        printf(" STATUS    : SCHEMATIC GENERATED; PERFORMANCE NOT VERIFIED\n")
        printf("============================================================\n")
        t
    )
)
