;=============================================================================
; Three-Stage OTA - TotalW V1 - 2026-08-17
; Cadence Virtuoso IC6.1.7 / SKILL - PDK target: tsmcN65 - 2026-08-17
;
; TotalW-first generator: W/finger = TotalW/NF, totalM = NF*M.
; Routing contract: one isolated labeled stub per terminal; no
; device-to-device wires. Schematic candidate; electrical performance
; is NOT verified. All source text is ASCII-only.
;
;   M1  NMOS input pair (G=VINP D=MIRROR S=TAIL B=VSS)
;   M2  NMOS input pair (G=VINN D=VOUT1 S=TAIL B=VSS)
;   M3  PMOS diode mirror (G=D=MIRROR S=VDD B=VDD)
;   M4  PMOS mirror load (G=MIRROR D=VOUT1 S=VDD B=VDD)
;   M5  NMOS tail source (G=VBN_TAIL D=TAIL S=VSS B=VSS)
;   M6  NMOS stage-2 input (G=VOUT1 D=VOUT2 S=VSS B=VSS)
;   M7  PMOS stage-2 load (G=MIRROR D=VOUT2 S=VDD B=VDD)
;   M8  NMOS stage-3 input (G=VOUT2 D=VOUT S=VSS B=VSS)
;   M9  PMOS stage-3 load (G=MIRROR D=VOUT S=VDD B=VDD)
;=============================================================================

(setq THS_LIB "tsmcN65")
(setq THS_NMOS "nch")
(setq THS_PMOS "pch")
(setq THS_STUB 0.75)
(setq THS_WIRE 0.0625)
procedure(THS_ToFloat(val)
    cond(
        (numberp(val) float(val))
        (stringp(val)
            let((parsed)
                parsed=nil
                errset(parsed=cdfParseFloatString(val) t)
                parsed
            )
        )
        (t nil)
    )
)

procedure(THS_ValueMatches(got expect)
    let((gn en)
        gn=THS_ToFloat(got)
        en=THS_ToFloat(expect)
        if(gn && en
            then abs(gn-en) < 1e-12 * max(1.0 abs(en))
            else equal(got expect)
        )
    )
)

procedure(THS_OpenMaster(lib cell)
    let((master)
        master=dbOpenCellViewByType(lib cell "symbol" "" "r")
        unless(master
            error("THS: cannot open %s/%s/symbol.\n" lib cell)
        )
        master
    )
)

procedure(THS_SetMOS(inst TotalW L NF M)
    let((cdf nfInt mInt WperFinger totalM)
        cdf=cdfGetInstCDF(inst)
        unless(cdf error("THS: CDF missing on %s.\n" inst~>name))
        unless(cdf->w && cdf->l && cdf->wf && cdf->fingers && cdf->simM && cdf->totalM && cdf->nf && cdf->m
            error("THS: incomplete MOS CDF on %s.\n" inst~>name))
        nfInt=atoi(NF)
        mInt=atoi(M)
        unless(nfInt>0 error("THS: NF must be >= 1 on %s.\n" inst~>name))
        unless(mInt>0 error("THS: M must be >= 1 on %s.\n" inst~>name))
        WperFinger=THS_ToFloat(TotalW)/float(nfInt)
        totalM=sprintf(nil "%d" (nfInt*mInt))
        cdf->w->value=sprintf(nil "%g" WperFinger)
        cdf->l->value=L
        cdf->wf->value=TotalW
        cdf->fingers->value=NF
        cdf->simM->value=M
        cdf->totalM->value=totalM
        cdf->nf->value=NF
        cdf->m->value=M
        unless(THS_ValueMatches(cdf->w->value WperFinger)
            error("THS: W/finger read-back mismatch on %s.\n" inst~>name))
        unless(THS_ValueMatches(cdf->l->value L)
            error("THS: L read-back mismatch on %s.\n" inst~>name))
        unless(THS_ValueMatches(cdf->wf->value TotalW)
            error("THS: TotalW read-back mismatch on %s.\n" inst~>name))
        unless(THS_ValueMatches(cdf->fingers->value NF)
            error("THS: fingers read-back mismatch on %s.\n" inst~>name))
        unless(THS_ValueMatches(cdf->simM->value M)
            error("THS: simM read-back mismatch on %s.\n" inst~>name))
        unless(THS_ValueMatches(cdf->totalM->value totalM)
            error("THS: totalM read-back mismatch on %s.\n" inst~>name))
        unless(THS_ValueMatches(cdf->nf->value NF)
            error("THS: nf read-back mismatch on %s.\n" inst~>name))
        unless(THS_ValueMatches(cdf->m->value M)
            error("THS: m read-back mismatch on %s.\n" inst~>name))
        printf("THS: %s TotalW=%s W/finger=%s L=%s NF=%s M=%s totalM=%s\n"
            inst~>name TotalW cdf->w->value L NF M totalM)
        t
    )
)

procedure(THS_PinCenter(inst pinName)
    let((term pin fig)
        term=dbFindTermByName(inst~>master pinName)
        unless(term error("THS: terminal %s missing on %s.\n" pinName inst~>name))
        pin=car(term~>pins)
        unless(pin error("THS: pin figure missing on %s.%s.\n" inst~>name pinName))
        fig=pin~>fig
        unless(fig error("THS: figure missing on %s.%s.\n" inst~>name pinName))
        dbTransformPoint(centerBox(fig~>bBox) inst~>transform)
    )
)

procedure(THS_PlaceMOS(cv master name xy TotalW L NF M orient)
    let((inst)
        inst=dbCreateInst(cv master name xy orient)
        unless(inst error("THS: cannot create %s.\n" name))
        THS_SetMOS(inst TotalW L NF M)
        inst
    )
)

procedure(THS_StubEnd(inst pinName)
    let((g b s d p ref dx dy)
        g=THS_PinCenter(inst "G")
        b=THS_PinCenter(inst "B")
        s=THS_PinCenter(inst "S")
        d=THS_PinCenter(inst "D")
        p=THS_PinCenter(inst pinName)
        cond(
            (equal(pinName "G") ref=b)
            (equal(pinName "B") ref=g)
            (equal(pinName "S") ref=d)
            (equal(pinName "D") ref=s)
            (t error("THS: unsupported terminal %s.\n" pinName))
        )
        dx=car(p)-car(ref)
        dy=cadr(p)-cadr(ref)
        if(abs(dx)>=abs(dy)
            then if(dx<0.0
                then list(car(p)-THS_STUB cadr(p))
                else list(car(p)+THS_STUB cadr(p)))
            else if(dy<0.0
                then list(car(p) cadr(p)-THS_STUB)
                else list(car(p) cadr(p)+THS_STUB))
        )
    )
)

procedure(THS_LabelMOSTerminal(cv inst pinName netName)
    let((p e wire label)
        p=THS_PinCenter(inst pinName)
        e=THS_StubEnd(inst pinName)
        wire=schCreateWire(cv "route" "full" list(p e) THS_WIRE THS_WIRE 0)
        unless(wire error("THS: stub creation failed on %s.%s.\n" inst~>name pinName))
        label=schCreateWireLabel(cv car(wire) e netName "lowerLeft" "R0" "stick" THS_WIRE nil)
        unless(label error("THS: label creation failed on %s.%s.\n" inst~>name pinName))
        printf("THS: STUB %s.%s -> %s\n" inst~>name pinName netName)
        e
    )
)

procedure(THS_SetVDC(inst value)
    let((cdf)
        cdf=cdfGetInstCDF(inst)
        unless(cdf error("THS: VDC CDF missing on %s.\n" inst~>name))
        unless(cdf->vdc error("THS: VDC parameter missing on %s.\n" inst~>name))
        cdf->vdc->value=value
        t
    )
)

procedure(THS_VDCPinCenter(inst pinName)
    let((term pin fig)
        term=dbFindTermByName(inst~>master pinName)
        unless(term error("THS: VDC terminal %s missing on %s.\n" pinName inst~>name))
        pin=car(term~>pins)
        unless(pin error("THS: VDC pin figure missing on %s.%s.\n" inst~>name pinName))
        fig=pin~>fig
        unless(fig error("THS: VDC figure missing on %s.%s.\n" inst~>name pinName))
        dbTransformPoint(centerBox(fig~>bBox) inst~>transform)
    )
)

procedure(THS_CreateVDC(cv master name xy value plusNet minusNet)
    let((inst plus minus ep em wp wm gndMaster gndInst)
        inst=dbCreateInst(cv master name xy "R0")
        unless(inst error("THS: cannot create VDC %s.\n" name))
        THS_SetVDC(inst value)
        plus=THS_VDCPinCenter(inst "PLUS")
        minus=THS_VDCPinCenter(inst "MINUS")
        ep=list(car(plus) cadr(plus)+THS_STUB)
        wp=schCreateWire(cv "route" "full" list(plus ep) THS_WIRE THS_WIRE 0)
        unless(wp error("THS: VDC PLUS wiring failed for %s.\n" name))
        schCreateWireLabel(cv car(wp) ep plusNet "lowerLeft" "R0" "stick" THS_WIRE nil)
        if(equal(plusNet "VSS") then
            gndMaster=THS_OpenMaster("analogLib" "gnd")
            gndInst=dbCreateInst(cv gndMaster strcat(name "_GND") minus "R0")
            unless(gndInst error("THS: cannot create GND instance for %s.\n" name))
        else
            em=list(car(minus) cadr(minus)-THS_STUB)
            wm=schCreateWire(cv "route" "full" list(minus em) THS_WIRE THS_WIRE 0)
            unless(wm error("THS: VDC MINUS wiring failed for %s.\n" name))
            schCreateWireLabel(cv car(wm) em minusNet "lowerLeft" "R0" "stick" THS_WIRE nil)
        )
        printf("THS: VDC %s = %sV PLUS=%s MINUS=%s\n" name value plusNet minusNet)
        inst
    )
)

procedure(THS_CreatePin(cv pinMaster name direction xy)
    let((pin)
        pin=schCreatePin(cv pinMaster name direction nil xy "R0")
        unless(pin error("THS: failed creating external pin %s.\n" name))
        printf("THS: PIN %s direction=%s at %L\n" name direction xy)
        pin
    )
)
procedure(THS_PlacePMOSAuto(cv master name xy TotalW L NF M)
    let((inst s d)
        inst=THS_PlaceMOS(cv master name xy TotalW L NF M "R0")
        s=THS_PinCenter(inst "S")
        d=THS_PinCenter(inst "D")
        printf("THS: PMOS %s candidate orient=%L S=%L D=%L\n" name inst~>orient s d)
        if(cadr(s)>cadr(d)
            then inst
            else
                dbDeleteObject(inst)
                inst=THS_PlaceMOS(cv master name xy TotalW L NF M "MX")
                s=THS_PinCenter(inst "S")
                d=THS_PinCenter(inst "D")
                printf("THS: PMOS %s fallback orient=%L S=%L D=%L\n" name inst~>orient s d)
                unless(cadr(s)>cadr(d)
                    error("THS: PMOS %s cannot place source above drain in R0 or MX.\n" name))
                inst
        )
    )
)

procedure(CreateThreeStage_OTA_TotalW_V1_20260817()
    let((cv nmos pmos vdcMaster pinMaster M1 M2 M3 M4 M5 M6 M7 M8 M9  V_VDD_SRC V_VBN_TAIL_SRC V_VINP_SRC V_VINN_SRC V_VSS_SRC)

        printf("\n============================================================\n")
        printf(" Three-Stage OTA - TotalW V1 - 2026-08-17\n")
        printf("============================================================\n")
        printf("VDD=1.50V  TAIL BIAS: V_VBN_TAIL = 0.60V  INPUTS: 0.75V\n")
        printf("Three cascaded gain stages; UNCOMPENSATED (no compensation capacitors)\n")
        printf("OUTPUT: VOUT = M8.D/M9.D  TEMP=27C  CORNER=TT\n")
        printf("DEVICE=THS/THS\n" THS_LIB THS_NMOS)
        printf("DEVICE=THS/THS\n" THS_LIB THS_PMOS)
        printf("STATUS=SCHEMATIC CANDIDATE; PERFORMANCE NOT VERIFIED\n")
        printf("============================================================\n")

        cv=geGetEditCellView()
        unless(cv error("THS: open a NEW EMPTY editable schematic first.\n"))
        unless(null(cv~>instances)
            error("THS: target schematic is not empty. Use a new empty schematic.\n"))

        nmos=THS_OpenMaster(THS_LIB THS_NMOS)
        pmos=THS_OpenMaster(THS_LIB THS_PMOS)
        vdcMaster=THS_OpenMaster("analogLib" "vdc")
        pinMaster=THS_OpenMaster("basic" "iopin")

        M1=THS_PlaceMOS(cv nmos "M1" -3:4 "2u" "240n" "1" "1" "R0")
        M2=THS_PlaceMOS(cv nmos "M2" 3:4 "2u" "240n" "1" "1" "R0")
        M3=THS_PlacePMOSAuto(cv pmos "M3" -3:10 "4u" "480n" "1" "1")
        M4=THS_PlacePMOSAuto(cv pmos "M4" 3:10 "4u" "480n" "1" "1")
        M5=THS_PlaceMOS(cv nmos "M5" 0:-2 "6u" "480n" "1" "1" "R0")
        M6=THS_PlaceMOS(cv nmos "M6" 8:-2 "4u" "480n" "1" "1" "R0")
        M7=THS_PlacePMOSAuto(cv pmos "M7" 8:4 "8u" "480n" "1" "1")
        M8=THS_PlaceMOS(cv nmos "M8" 14:-2 "4u" "480n" "1" "1" "R0")
        M9=THS_PlacePMOSAuto(cv pmos "M9" 14:4 "8u" "480n" "1" "1")

        THS_LabelMOSTerminal(cv M1 "G" "VINP")
        THS_LabelMOSTerminal(cv M1 "D" "MIRROR")
        THS_LabelMOSTerminal(cv M1 "S" "TAIL")
        THS_LabelMOSTerminal(cv M1 "B" "VSS")
        THS_LabelMOSTerminal(cv M2 "G" "VINN")
        THS_LabelMOSTerminal(cv M2 "D" "VOUT1")
        THS_LabelMOSTerminal(cv M2 "S" "TAIL")
        THS_LabelMOSTerminal(cv M2 "B" "VSS")
        THS_LabelMOSTerminal(cv M3 "G" "MIRROR")
        THS_LabelMOSTerminal(cv M3 "D" "MIRROR")
        THS_LabelMOSTerminal(cv M3 "S" "VDD")
        THS_LabelMOSTerminal(cv M3 "B" "VDD")
        THS_LabelMOSTerminal(cv M4 "G" "MIRROR")
        THS_LabelMOSTerminal(cv M4 "D" "VOUT1")
        THS_LabelMOSTerminal(cv M4 "S" "VDD")
        THS_LabelMOSTerminal(cv M4 "B" "VDD")
        THS_LabelMOSTerminal(cv M5 "G" "VBN_TAIL")
        THS_LabelMOSTerminal(cv M5 "D" "TAIL")
        THS_LabelMOSTerminal(cv M5 "S" "VSS")
        THS_LabelMOSTerminal(cv M5 "B" "VSS")
        THS_LabelMOSTerminal(cv M6 "G" "VOUT1")
        THS_LabelMOSTerminal(cv M6 "D" "VOUT2")
        THS_LabelMOSTerminal(cv M6 "S" "VSS")
        THS_LabelMOSTerminal(cv M6 "B" "VSS")
        THS_LabelMOSTerminal(cv M7 "G" "MIRROR")
        THS_LabelMOSTerminal(cv M7 "D" "VOUT2")
        THS_LabelMOSTerminal(cv M7 "S" "VDD")
        THS_LabelMOSTerminal(cv M7 "B" "VDD")
        THS_LabelMOSTerminal(cv M8 "G" "VOUT2")
        THS_LabelMOSTerminal(cv M8 "D" "VOUT")
        THS_LabelMOSTerminal(cv M8 "S" "VSS")
        THS_LabelMOSTerminal(cv M8 "B" "VSS")
        THS_LabelMOSTerminal(cv M9 "G" "MIRROR")
        THS_LabelMOSTerminal(cv M9 "D" "VOUT")
        THS_LabelMOSTerminal(cv M9 "S" "VDD")
        THS_LabelMOSTerminal(cv M9 "B" "VDD")

        V_VDD_SRC=THS_CreateVDC(cv vdcMaster "V_VDD_SRC" 0:16 "1.50" "VDD" "VSS")
        V_VBN_TAIL_SRC=THS_CreateVDC(cv vdcMaster "V_VBN_TAIL_SRC" -12:0 "0.60" "VBN_TAIL" "VSS")
        V_VINP_SRC=THS_CreateVDC(cv vdcMaster "V_VINP_SRC" -12:-4 "0.75" "VINP" "VSS")
        V_VINN_SRC=THS_CreateVDC(cv vdcMaster "V_VINN_SRC" -12:-8 "0.75" "VINN" "VSS")
        V_VSS_SRC=THS_CreateVDC(cv vdcMaster "V_VSS_SRC" 0:-8 "0.0" "VSS" "VSS")

        THS_CreatePin(cv pinMaster "VINP" "input" -10:-8)
        THS_CreatePin(cv pinMaster "VINN" "input" -7:-8)
        THS_CreatePin(cv pinMaster "VOUT" "output" 18:1)
        THS_CreatePin(cv pinMaster "VDD" "input" 0:18)
        THS_CreatePin(cv pinMaster "VSS" "input" 0:-10)

        schCheck(cv)
        dbSave(cv)

        printf("\n============================================================\n")
        printf(" THS GENERATOR COMPLETED\n")
        printf(" CDF       : w/l/wf/fingers/simM/totalM/nf/m explicit\n")
        printf(" ROUTING   : local isolated stub + net label\n")
        printf(" STATUS    : SCHEMATIC GENERATED; PERFORMANCE NOT VERIFIED\n")
        printf("============================================================\n")
        t
    )
)
